** sch_path: /mnt/a/Marvel_project/inverter/xschem/inverter_tb.sch
**.subckt inverter_tb out in
*.opin out
*.opin in
x1 in out GND vdd inverter
V1 in GND PWL(0 0 20n 0 900n 1.8)
V2 vdd GND 1.8
**** begin user architecture code

 .lib /usr/local/share/pdk/sky130A/libs.tech/ngspice/sky130.lib.spice tt

.control
tran 1n 1u
plot v(in) v(out)
.endc

**** end user architecture code
**.ends.ends

.include inverter.spice

.GLOBAL GND
.end
