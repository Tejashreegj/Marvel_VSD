** sch_path: /mnt/a/Marvel_project/inverter/xschem/inverter_tb.sch
**.subckt inverter_tb out in
*.opin out
*.opin in
x1 net1 in out GND inverter
V1 in GND PWL(0 0 20n 0 900n 1.8)
V2 net1 GND 1.8
**** begin user architecture code

 .lib /usr/local/share/pdk/sky130A/libs.tech/ngspice/sky130.lib.spice tt

.control
tran 1n 1u
plot v(in) v(out)
.endc

**** end user architecture code
**.ends

* expanding   symbol:  inverter.sym # of pins=4
** sym_path: /mnt/a/Marvel_project/inverter/xschem/inverter.sym
** sch_path: /mnt/a/Marvel_project/inverter/xschem/inverter.sch
.subckt inverter vdd in out vss
*.ipin in
*.opin out
*.iopin vss
*.iopin vdd
XM1 out in vss vss sky130_fd_pr__nfet_01v8 L=0.18 W=4.5 nf=3 ad=0.87 as=1.74 pd=4.16 ps=8.32
+ nrd=0.1933333 nrs=0.1933333 sa=0 sb=0 sd=0 mult=1 m=1
XM2 out in vdd vdd sky130_fd_pr__pfet_01v8 L=0.18 W=3 nf=3 ad=0.58 as=1.16 pd=3.16 ps=6.32 nrd=0.29
+ nrs=0.29 sa=0 sb=0 sd=0 mult=1 m=1
.ends

.GLOBAL GND
.end
